/* Autogenerated Complex SystemRDL */

addrmap SystemCtrl_ctrl_map {
  regfile SystemCtrl_gf {
    reg GlobalConfig_t {
      field { sw=rw; hw=r; reset=0x0; desc="System-wide mode control"; } Mode [1:0];
      field { sw=w; hw=r; reset=0x0; desc="Write-only power enable"; } Power [2:2];
    } GlobalConfig @ 0x0;
  } SystemCtrl[1] @= 0x40;
  regfile TimerGroup_gf {
    regfile Ctrl_sgf {
      reg TimerLoad_t {
        field { sw=rw; hw=r; reset=0x0; desc="Load timer"; } LoadValue [31:0];
      } TimerLoad @ 0x40;
    } Ctrl[1] @= 0x20;
  } TimerGroup[2] @= 0x80;
  regfile PeripheralCtrl_gf {
    reg singleRepeat_t {
    } singleRepeat[4] @= 0x10 @ 0x300;
    reg longlong_t {
    } longlong @ 0x4ac;
  } PeripheralCtrl[1] @= 0x100;
} SystemCtrl_ctrl @ 0x0;

addrmap _group_map {
  regfile SystemCtrl_gf {
    reg GlobalConfig_t {
      field { sw=rw; hw=r; reset=0x0; desc="System-wide mode control"; } Mode [1:0];
      field { sw=w; hw=r; reset=0x0; desc="Write-only power enable"; } Power [2:2];
    } GlobalConfig @ 0x0;
  } SystemCtrl[1] @= 0x40;
  regfile TimerGroup_gf {
    regfile Ctrl_sgf {
      reg TimerLoad_t {
        field { sw=rw; hw=r; reset=0x0; desc="Load timer"; } LoadValue [31:0];
      } TimerLoad @ 0x40;
    } Ctrl[1] @= 0x20;
  } TimerGroup[2] @= 0x80;
  regfile PeripheralCtrl_gf {
    reg singleRepeat_t {
    } singleRepeat[4] @= 0x10 @ 0x300;
    reg longlong_t {
    } longlong @ 0x4ac;
  } PeripheralCtrl[1] @= 0x100;
} _group @ 0x10000;

addrmap _io_map {
  regfile SystemCtrl_gf {
    reg GlobalConfig_t {
      field { sw=rw; hw=r; reset=0x0; desc="System-wide mode control"; } Mode [1:0];
      field { sw=w; hw=r; reset=0x0; desc="Write-only power enable"; } Power [2:2];
    } GlobalConfig @ 0x0;
  } SystemCtrl[1] @= 0x40;
  regfile TimerGroup_gf {
    regfile Ctrl_sgf {
      reg TimerLoad_t {
        field { sw=rw; hw=r; reset=0x0; desc="Load timer"; } LoadValue [31:0];
      } TimerLoad @ 0x40;
    } Ctrl[1] @= 0x20;
  } TimerGroup[2] @= 0x80;
  regfile PeripheralCtrl_gf {
    reg singleRepeat_t {
    } singleRepeat[4] @= 0x10 @ 0x300;
    reg longlong_t {
    } longlong @ 0x4ac;
  } PeripheralCtrl[1] @= 0x100;
} _io @ 0x20000;

addrmap PeripheralCtrl_peri_map {
  regfile SystemCtrl_gf {
    reg GlobalConfig_t {
      field { sw=rw; hw=r; reset=0x0; desc="System-wide mode control"; } Mode [1:0];
      field { sw=w; hw=r; reset=0x0; desc="Write-only power enable"; } Power [2:2];
    } GlobalConfig @ 0x0;
  } SystemCtrl[1] @= 0x40;
  regfile TimerGroup_gf {
    regfile Ctrl_sgf {
      reg TimerLoad_t {
        field { sw=rw; hw=r; reset=0x0; desc="Load timer"; } LoadValue [31:0];
      } TimerLoad @ 0x40;
    } Ctrl[1] @= 0x20;
  } TimerGroup[2] @= 0x80;
  regfile PeripheralCtrl_gf {
    reg singleRepeat_t {
    } singleRepeat[4] @= 0x10 @ 0x300;
    reg longlong_t {
    } longlong @ 0x4ac;
  } PeripheralCtrl[1] @= 0x100;
} PeripheralCtrl_peri @ 0x30000000;

addrmap MainComplex_main_map {
  regfile SystemCtrl_gf {
    reg GlobalConfig_t {
      field { sw=rw; hw=r; reset=0x0; desc="System-wide mode control"; } Mode [1:0];
      field { sw=w; hw=r; reset=0x0; desc="Write-only power enable"; } Power [2:2];
    } GlobalConfig @ 0x0;
  } SystemCtrl[1] @= 0x40;
  regfile TimerGroup_gf {
    regfile Ctrl_sgf {
      reg TimerLoad_t {
        field { sw=rw; hw=r; reset=0x0; desc="Load timer"; } LoadValue [31:0];
      } TimerLoad @ 0x40;
    } Ctrl[1] @= 0x20;
  } TimerGroup[2] @= 0x80;
  regfile PeripheralCtrl_gf {
    reg singleRepeat_t {
    } singleRepeat[4] @= 0x10 @ 0x300;
    reg longlong_t {
    } longlong @ 0x4ac;
  } PeripheralCtrl[1] @= 0x100;
} MainComplex_main @ 0x40000000;

addrmap SubComplexA_sub_a_map {
  regfile SystemCtrl_gf {
    reg GlobalConfig_t {
      field { sw=rw; hw=r; reset=0x0; desc="System-wide mode control"; } Mode [1:0];
      field { sw=w; hw=r; reset=0x0; desc="Write-only power enable"; } Power [2:2];
    } GlobalConfig @ 0x0;
  } SystemCtrl[1] @= 0x40;
  regfile TimerGroup_gf {
    regfile Ctrl_sgf {
      reg TimerLoad_t {
        field { sw=rw; hw=r; reset=0x0; desc="Load timer"; } LoadValue [31:0];
      } TimerLoad @ 0x40;
    } Ctrl[1] @= 0x20;
  } TimerGroup[2] @= 0x80;
  regfile PeripheralCtrl_gf {
    reg singleRepeat_t {
    } singleRepeat[4] @= 0x10 @ 0x300;
    reg longlong_t {
    } longlong @ 0x4ac;
  } PeripheralCtrl[1] @= 0x100;
} SubComplexA_sub_a @ 0x50000000;

addrmap SubComplexB_sub_b_map {
  regfile SystemCtrl_gf {
    reg GlobalConfig_t {
      field { sw=rw; hw=r; reset=0x0; desc="System-wide mode control"; } Mode [1:0];
      field { sw=w; hw=r; reset=0x0; desc="Write-only power enable"; } Power [2:2];
    } GlobalConfig @ 0x0;
  } SystemCtrl[1] @= 0x40;
  regfile TimerGroup_gf {
    regfile Ctrl_sgf {
      reg TimerLoad_t {
        field { sw=rw; hw=r; reset=0x0; desc="Load timer"; } LoadValue [31:0];
      } TimerLoad @ 0x40;
    } Ctrl[1] @= 0x20;
  } TimerGroup[2] @= 0x80;
  regfile PeripheralCtrl_gf {
    reg singleRepeat_t {
    } singleRepeat[4] @= 0x10 @ 0x300;
    reg longlong_t {
    } longlong @ 0x4ac;
  } PeripheralCtrl[1] @= 0x100;
} SubComplexB_sub_b @ 0x60000000;
